.lib /usr/local/share/pdk/sky130A/libs.tech/ngspice/sky130.lib.spice tt
.include fa.spice
VDD VDD 0 1.8
VA0 A0 0 PWL(0n 1.8 19.9n 1.8 20n 1.8 39.9n 1.8 40n 1.8 59.9n 1.8 60n 0.0 79.9n 0.0 80n 1.8 99.9n 1.8)
VB0 B0 0 PWL(0n 1.8 19.9n 1.8 20n 0.0 39.9n 0.0 40n 1.8 59.9n 1.8 60n 0.0 79.9n 0.0 80n 1.8 99.9n 1.8)
VA1 A1 0 PWL(0n 0.0 19.9n 0.0 20n 0.0 39.9n 0.0 40n 1.8 59.9n 1.8 60n 0.0 79.9n 0.0 80n 1.8 99.9n 1.8)
VB1 B1 0 PWL(0n 1.8 19.9n 1.8 20n 1.8 39.9n 1.8 40n 1.8 59.9n 1.8 60n 0.0 79.9n 0.0 80n 1.8 99.9n 1.8)
VA2 A2 0 PWL(0n 0.0 19.9n 0.0 20n 1.8 39.9n 1.8 40n 1.8 59.9n 1.8 60n 0.0 79.9n 0.0 80n 1.8 99.9n 1.8)
VB2 B2 0 PWL(0n 0.0 19.9n 0.0 20n 1.8 39.9n 1.8 40n 1.8 59.9n 1.8 60n 0.0 79.9n 0.0 80n 1.8 99.9n 1.8)
VA3 A3 0 PWL(0n 0.0 19.9n 0.0 20n 0.0 39.9n 0.0 40n 1.8 59.9n 1.8 60n 0.0 79.9n 0.0 80n 1.8 99.9n 1.8)
VB3 B3 0 PWL(0n 0.0 19.9n 0.0 20n 0.0 39.9n 0.0 40n 1.8 59.9n 1.8 60n 0.0 79.9n 0.0 80n 1.8 99.9n 1.8)
VCIN Cin 0 PWL(0n 0.0 19.9n 0.0 20n 1.8 39.9n 1.8 40n 0.0 59.9n 0.0 60n 0.0 79.9n 0.0 80n 1.8 99.9n 1.8)
X0 A0 B0 Cin S0 c1 VDD 0 fa
X1 A1 B1 c1 S1 c2 VDD 0 fa
X2 A2 B2 c2 S2 c3 VDD 0 fa
X3 A3 B3 c3 S3 Cout VDD 0 fa
.tran 0.05n 100n
.control
run
wrdata out.txt v(S0) v(S1) v(S2) v(S3) v(Cout)
quit
.endc
.end
